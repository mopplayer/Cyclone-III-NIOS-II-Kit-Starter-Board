|   dav0
|   IBIS Model of EP3C25F324
|   FPGA dev board
|   324 BGA Package
[IBIS Ver]   4.1
[File name]   ep3c25f_dev.ibs
[File Rev]   2.2
[Date]   01/04/10
[Source]   Altera Corporation
[Notes]   When you have a design you can create your own from QuartusII.
[Disclaimer]
Data is for modeling purposes only and is not guaranteed.
[Copyright]
[Component]   ep3c25f
[Manufacturer]  Altera Corp
[Package]
|   typ   min   max
R_pkg   50.0m   NA   NA
L_pkg   1.37nH   NA   NA
C_pkg   0.1pF   NA   NA
[Pin]   signal_name   model_name   R_pin   L_pin   C_pin
U2 DDR_CLK_P lvds25_ro_e3r 50.0m 1.49n 0.306p
V2 DDR_CLK_N lvds25_ro_e3r 50.0m 1.49n 0.306p
F17 HSMC_CLKIN_P1 lvds25_rdin 50.0m 1.49n 0.306p
F18 HSMC_CLKIN_N1 lvds25_rdin 50.0m 1.49n 0.306p
N17 HSMC_CLKIN_P2 lvds25_rdin 50.0m 1.49n 0.306p
N18 HSMC_CLKIN_N2 lvds25_rdin 50.0m 1.49n 0.306p
D14 HSMC_CLKOUT_P1 lvds25_co_e3r 50.0m 1.49n 0.306p
C14 HSMC_CLKOUT_N1 lvds25_co_e3r 50.0m 1.49n 0.306p
U18 HSMC_CLKOUT_P2 lvds25_ro_e3r 50.0m 1.49n 0.306p
V18 HSMC_CLKOUT_N2 lvds25_ro_e3r 50.0m 1.49n 0.306p
G17 HSMC_RX_P10 lvds25_rdin 50.0m 1.49n 0.306p
G18 HSMC_RX_N10 lvds25_rdin 50.0m 1.49n 0.306p
K18 HSMC_RX_P11 lvds25_rdin 50.0m 1.49n 0.306p
L18 HSMC_RX_N11 lvds25_rdin 50.0m 1.49n 0.306p
L16 HSMC_RX_P12 lvds25_rdin 50.0m 1.49n 0.306p
M17 HSMC_RX_N12 lvds25_rdin 50.0m 1.49n 0.306p
L13 HSMC_RX_P13 lvds25_rdin 50.0m 1.49n 0.306p
M14 HSMC_RX_N13 lvds25_rdin 50.0m 1.49n 0.306p
R17 HSMC_RX_P14 lvds25_rdin 50.0m 1.49n 0.306p
R18 HSMC_RX_N14 lvds25_rdin 50.0m 1.49n 0.306p
M6 HSMC_RX_P15 lvds25_cin 50.0m 1.49n 0.306p
N6 HSMC_RX_N15 lvds25_cin 50.0m 1.49n 0.306p
M13 HSMC_RX_P16 lvds25_cin 50.0m 1.49n 0.306p
N13 HSMC_RX_N16 lvds25_cin 50.0m 1.49n 0.306p
C2 HSMC_RX_P4 lvds25_rdin 50.0m 1.49n 0.306p
C1 HSMC_RX_N4 lvds25_rdin 50.0m 1.49n 0.306p
H2 HSMC_RX_P5 lvds25_rdin 50.0m 1.49n 0.306p
H1 HSMC_RX_N5 lvds25_rdin 50.0m 1.49n 0.306p
K5 HSMC_RX_P6 lvds25_rdin 50.0m 1.49n 0.306p
L5 HSMC_RX_N6 lvds25_rdin 50.0m 1.49n 0.306p
L4 HSMC_RX_P7 lvds25_rdin 50.0m 1.49n 0.306p
L3 HSMC_RX_N7 lvds25_rdin 50.0m 1.49n 0.306p
P2 HSMC_RX_P8 lvds25_rdin 50.0m 1.49n 0.306p
P1 HSMC_RX_N8 lvds25_rdin 50.0m 1.49n 0.306p
T3 HSMC_RX_P9 lvds25_rdin 50.0m 1.49n 0.306p
R3 HSMC_RX_N9 lvds25_rdin 50.0m 1.49n 0.306p
E17 HSMC_TX_P10 lvds25_ro_e3r 50.0m 1.49n 0.306p
E18 HSMC_TX_N10 lvds25_ro_e3r 50.0m 1.49n 0.306p
H17 HSMC_TX_P11 lvds25_ro_e3r 50.0m 1.49n 0.306p
H18 HSMC_TX_N11 lvds25_ro_e3r 50.0m 1.49n 0.306p
L17 HSMC_TX_P12 lvds25_ro_e3r 50.0m 1.49n 0.306p
M18 HSMC_TX_N12 lvds25_ro_e3r 50.0m 1.49n 0.306p
L14 HSMC_TX_P13 lvds25_ro_e3r 50.0m 1.49n 0.306p
L15 HSMC_TX_N13 lvds25_ro_e3r 50.0m 1.49n 0.306p
P17 HSMC_TX_P14 lvds25_ro_e3r 50.0m 1.49n 0.306p
P18 HSMC_TX_N14 lvds25_ro_e3r 50.0m 1.49n 0.306p
R5 HSMC_TX_P15 lvds25_ro_e3r 50.0m 1.49n 0.306p
R4 HSMC_TX_N15 lvds25_ro_e3r 50.0m 1.49n 0.306p
T17 HSMC_TX_P16 lvds25_ro_e3r 50.0m 1.49n 0.306p
T18 HSMC_TX_N16 lvds25_ro_e3r 50.0m 1.49n 0.306p
B2 HSMC_TX_P4 lvds25_ro_e3r 50.0m 1.49n 0.306p
B1 HSMC_TX_N4 lvds25_ro_e3r 50.0m 1.49n 0.306p
G2 HSMC_TX_P5 lvds25_ro_e3r 50.0m 1.49n 0.306p
G1 HSMC_TX_N5 lvds25_ro_e3r 50.0m 1.49n 0.306p
K2 HSMC_TX_P6 lvds25_ro_e3r 50.0m 1.49n 0.306p
K1 HSMC_TX_N6 lvds25_ro_e3r 50.0m 1.49n 0.306p
L2 HSMC_TX_P7 lvds25_ro_e3r 50.0m 1.49n 0.306p
L1 HSMC_TX_N7 lvds25_ro_e3r 50.0m 1.49n 0.306p
M2 HSMC_TX_P8 lvds25_ro_e3r 50.0m 1.49n 0.306p
M1 HSMC_TX_N8 lvds25_ro_e3r 50.0m 1.49n 0.306p
R2 HSMC_TX_P9 lvds25_ro_e3r 50.0m 1.49n 0.306p
R1 HSMC_TX_N9 lvds25_ro_e3r 50.0m 1.49n 0.306p
V9 50MHZ ttl25_rdin 50.0m 1.49n 0.306p
N2 CPU_RST_N ttl25_rdin 50.0m 1.49n 0.306p
U1 DDR_A0 ttl25_rdio_d8m 50.0m 1.49n 0.306p
U5 DDR_A1 ttl25_rdio_d8m 50.0m 1.49n 0.306p
U17 DDR_A10 ttl25_rdio_d8m 50.0m 1.49n 0.306p
V17 DDR_A11 ttl25_rdio_d8m 50.0m 1.49n 0.306p
U16 DDR_A12 ttl25_rdio_d8m 50.0m 1.49n 0.306p
U7 DDR_A2 ttl25_rdio_d8m 50.0m 1.49n 0.306p
U8 DDR_A3 ttl25_rdio_d8m 50.0m 1.49n 0.306p
P8 DDR_A4 ttl25_cio_d8m 50.0m 1.49n 0.306p
P7 DDR_A5 ttl25_cio_d8m 50.0m 1.49n 0.306p
P6 DDR_A6 ttl25_cio_d8m 50.0m 1.49n 0.306p
T14 DDR_A7 ttl25_cio_d8m 50.0m 1.49n 0.306p
T13 DDR_A8 ttl25_cio_d8m 50.0m 1.49n 0.306p
V13 DDR_A9 ttl25_rdio_d8m 50.0m 1.49n 0.306p
V11 DDR_BA0 ttl25_rdio_d8m 50.0m 1.49n 0.306p
V12 DDR_BA1 ttl25_rdio_d8m 50.0m 1.49n 0.306p
T4 DDR_CAS_N ttl25_cio_d8m 50.0m 1.49n 0.306p
R13 DDR_CKE ttl25_cio_d8m 50.0m 1.49n 0.306p
V1 DDR_CS_N ttl25_rdio_d8m 50.0m 1.49n 0.306p
V3 DDR_DM0 ttl25_rdio_d8m 50.0m 1.49n 0.306p
V8 DDR_DM1 ttl25_rdio_d8m 50.0m 1.49n 0.306p
U4 DDR_DQ0 ttl25_rdio_d8m 50.0m 1.49n 0.306p
V4 DDR_DQ1 ttl25_rdio_d8m 50.0m 1.49n 0.306p
U11 DDR_DQ10 ttl25_rdio_d8m 50.0m 1.49n 0.306p
V15 DDR_DQ11 ttl25_rdio_d8m 50.0m 1.49n 0.306p
U14 DDR_DQ12 ttl25_rdio_d8m 50.0m 1.49n 0.306p
R11 DDR_DQ13 ttl25_cio_d8m 50.0m 1.49n 0.306p
P10 DDR_DQ14 ttl25_cio_d8m 50.0m 1.49n 0.306p
V14 DDR_DQ15 ttl25_rdio_d8m 50.0m 1.49n 0.306p
R8 DDR_DQ2 ttl25_cio_d8m 50.0m 1.49n 0.306p
V5 DDR_DQ3 ttl25_rdio_d8m 50.0m 1.49n 0.306p
P9 DDR_DQ4 ttl25_cio_d8m 50.0m 1.49n 0.306p
U6 DDR_DQ5 ttl25_rdio_d8m 50.0m 1.49n 0.306p
V6 DDR_DQ6 ttl25_rdio_d8m 50.0m 1.49n 0.306p
V7 DDR_DQ7 ttl25_rdio_d8m 50.0m 1.49n 0.306p
U13 DDR_DQ8 ttl25_rdio_d8m 50.0m 1.49n 0.306p
U12 DDR_DQ9 ttl25_rdio_d8m 50.0m 1.49n 0.306p
U3 DDR_DQS0 ttl25_rdio_d8m 50.0m 1.49n 0.306p
T8 DDR_DQS1 ttl25_cio_d8m 50.0m 1.49n 0.306p
V16 DDR_RAS_N ttl25_rdio_d8m 50.0m 1.49n 0.306p
U15 DDR_WE_N ttl25_rdio_d8m 50.0m 1.49n 0.306p
H14 FLASH_ADV_N ttl25_rdio_d8m 50.0m 1.49n 0.306p
E2 FLASH_CE_N ttl25_rdio_d8m 50.0m 1.49n 0.306p
H4 FLASH_CLK ttl25_rdio_d8m 50.0m 1.49n 0.306p
D17 FLASH_OE_N ttl25_rdio_d8m 50.0m 1.49n 0.306p
C3 FLASH_RESET_N ttl25_rdio_d8m 50.0m 1.49n 0.306p
E12 FLASH_SRAM_A1 ttl25_cio_d8m 50.0m 1.49n 0.306p
A12 FLASH_SRAM_A10 ttl25_cio_d8m 50.0m 1.49n 0.306p
B12 FLASH_SRAM_A11 ttl25_cio_d8m 50.0m 1.49n 0.306p
A11 FLASH_SRAM_A12 ttl25_cio_d8m 50.0m 1.49n 0.306p
B11 FLASH_SRAM_A13 ttl25_cio_d8m 50.0m 1.49n 0.306p
C10 FLASH_SRAM_A14 ttl25_cio_d8m 50.0m 1.49n 0.306p
D10 FLASH_SRAM_A15 ttl25_cio_d8m 50.0m 1.49n 0.306p
E10 FLASH_SRAM_A16 ttl25_cio_d8m 50.0m 1.49n 0.306p
C9 FLASH_SRAM_A17 ttl25_cio_d8m 50.0m 1.49n 0.306p
D9 FLASH_SRAM_A18 ttl25_cio_d8m 50.0m 1.49n 0.306p
A7 FLASH_SRAM_A19 ttl25_cio_d8m 50.0m 1.49n 0.306p
A16 FLASH_SRAM_A2 ttl25_cio_d8m 50.0m 1.49n 0.306p
A6 FLASH_SRAM_A20 ttl25_cio_d8m 50.0m 1.49n 0.306p
B18 FLASH_SRAM_A21 ttl25_rdio_d8m 50.0m 1.49n 0.306p
C17 FLASH_SRAM_A22 ttl25_rdio_d8m 50.0m 1.49n 0.306p
C18 FLASH_SRAM_A23 ttl25_rdio_d8m 50.0m 1.49n 0.306p
G14 FLASH_SRAM_A24 ttl25_rdio_d8m 50.0m 1.49n 0.306p
B17 FLASH_SRAM_A25 ttl25_rdio_d8m 50.0m 1.49n 0.306p
B16 FLASH_SRAM_A3 ttl25_cio_d8m 50.0m 1.49n 0.306p
A15 FLASH_SRAM_A4 ttl25_cio_d8m 50.0m 1.49n 0.306p
B15 FLASH_SRAM_A5 ttl25_cio_d8m 50.0m 1.49n 0.306p
A14 FLASH_SRAM_A6 ttl25_cio_d8m 50.0m 1.49n 0.306p
B14 FLASH_SRAM_A7 ttl25_cio_d8m 50.0m 1.49n 0.306p
A13 FLASH_SRAM_A8 ttl25_cio_d8m 50.0m 1.49n 0.306p
B13 FLASH_SRAM_A9 ttl25_cio_d8m 50.0m 1.49n 0.306p
H3 FLASH_SRAM_DQ0 ttl25_rdio_d8m 50.0m 1.49n 0.306p
D1 FLASH_SRAM_DQ1 ttl25_rdio_d8m 50.0m 1.49n 0.306p
A3 FLASH_SRAM_DQ10 ttl25_cio_d8m 50.0m 1.49n 0.306p
B3 FLASH_SRAM_DQ11 ttl25_cio_d8m 50.0m 1.49n 0.306p
D5 FLASH_SRAM_DQ12 ttl25_cio_d8m 50.0m 1.49n 0.306p
B5 FLASH_SRAM_DQ13 ttl25_cio_d8m 50.0m 1.49n 0.306p
A5 FLASH_SRAM_DQ14 ttl25_cio_d8m 50.0m 1.49n 0.306p
B6 FLASH_SRAM_DQ15 ttl25_cio_d8m 50.0m 1.49n 0.306p
C16 FLASH_SRAM_DQ16 ttl25_cio_d8m 50.0m 1.49n 0.306p
D12 FLASH_SRAM_DQ17 ttl25_cio_d8m 50.0m 1.49n 0.306p
E11 FLASH_SRAM_DQ18 ttl25_cio_d8m 50.0m 1.49n 0.306p
D2 FLASH_SRAM_DQ19 ttl25_rdio_d8m 50.0m 1.49n 0.306p
A8 FLASH_SRAM_DQ2 ttl25_cio_d8m 50.0m 1.49n 0.306p
E13 FLASH_SRAM_DQ20 ttl25_cio_d8m 50.0m 1.49n 0.306p
E14 FLASH_SRAM_DQ21 ttl25_cio_d8m 50.0m 1.49n 0.306p
A17 FLASH_SRAM_DQ22 ttl25_cio_d8m 50.0m 1.49n 0.306p
D16 FLASH_SRAM_DQ23 ttl25_cio_d8m 50.0m 1.49n 0.306p
C12 FLASH_SRAM_DQ24 ttl25_cio_d8m 50.0m 1.49n 0.306p
A18 FLASH_SRAM_DQ25 ttl25_cio_d8m 50.0m 1.49n 0.306p
F8 FLASH_SRAM_DQ26 ttl25_cio_d8m 50.0m 1.49n 0.306p
D7 FLASH_SRAM_DQ27 ttl25_cio_d8m 50.0m 1.49n 0.306p
F6 FLASH_SRAM_DQ28 ttl25_cio_d8m 50.0m 1.49n 0.306p
E6 FLASH_SRAM_DQ29 ttl25_cio_d8m 50.0m 1.49n 0.306p
B8 FLASH_SRAM_DQ3 ttl25_cio_d8m 50.0m 1.49n 0.306p
G6 FLASH_SRAM_DQ30 ttl25_cio_d8m 50.0m 1.49n 0.306p
C7 FLASH_SRAM_DQ31 ttl25_cio_d8m 50.0m 1.49n 0.306p
B7 FLASH_SRAM_DQ4 ttl25_cio_d8m 50.0m 1.49n 0.306p
C5 FLASH_SRAM_DQ5 ttl25_cio_d8m 50.0m 1.49n 0.306p
E8 FLASH_SRAM_DQ6 ttl25_cio_d8m 50.0m 1.49n 0.306p
A4 FLASH_SRAM_DQ7 ttl25_cio_d8m 50.0m 1.49n 0.306p
B4 FLASH_SRAM_DQ8 ttl25_cio_d8m 50.0m 1.49n 0.306p
E7 FLASH_SRAM_DQ9 ttl25_cio_d8m 50.0m 1.49n 0.306p
H13 FLASH_WAIT ttl25_rdin 50.0m 1.49n 0.306p
D18 FLASH_WE_N ttl25_rdio_d8m 50.0m 1.49n 0.306p
A9 HSMC_CLKIN0 ttl25_cin 50.0m 1.49n 0.306p
A1 HSMC_CLKOUT0 ttl25_cio_d8m 50.0m 1.49n 0.306p
H6 HSMC_D0 ttl25_rdio_d8m 50.0m 1.49n 0.306p
D3 HSMC_D1 ttl25_rdio_d8m 50.0m 1.49n 0.306p
J13 HSMC_D10 ttl25_rdio_d8m 50.0m 1.49n 0.306p
H16 HSMC_D11 ttl25_rdio_d8m 50.0m 1.49n 0.306p
N10 HSMC_D12 ttl25_cio_d8m 50.0m 1.49n 0.306p
N16 HSMC_D13 ttl25_rdio_d8m 50.0m 1.49n 0.306p
N11 HSMC_D14 ttl25_cio_d8m 50.0m 1.49n 0.306p
N15 HSMC_D15 ttl25_rdio_d8m 50.0m 1.49n 0.306p
K17 HSMC_D16 ttl25_rdio_d8m 50.0m 1.49n 0.306p
R16 HSMC_D17 ttl25_rdio_d8m 50.0m 1.49n 0.306p
P11 HSMC_D18 ttl25_cio_d8m 50.0m 1.49n 0.306p
T16 HSMC_D19 ttl25_rdio_d8m 50.0m 1.49n 0.306p
M5 HSMC_D2 ttl25_rdio_d8m 50.0m 1.49n 0.306p
L6 HSMC_D3 ttl25_rdio_d8m 50.0m 1.49n 0.306p
T1 HSMC_D4 ttl25_rdio_d8m 50.0m 1.49n 0.306p
M3 HSMC_D5 ttl25_rdio_d8m 50.0m 1.49n 0.306p
N7 HSMC_D6 ttl25_cio_d8m 50.0m 1.49n 0.306p
T2 HSMC_D7 ttl25_rdio_d8m 50.0m 1.49n 0.306p
N8 HSMC_D8 ttl25_cio_d8m 50.0m 1.49n 0.306p
H15 HSMC_D9 ttl25_rdio_d8m 50.0m 1.49n 0.306p
F3 HSMC_SCL ttl25_rdio_d8m 50.0m 1.49n 0.306p
E1 HSMC_SDA ttl25_rdio_d8m 50.0m 1.49n 0.306p
F1 KEY0 ttl25_rdin 50.0m 1.49n 0.306p
F2 KEY1 ttl25_rdin 50.0m 1.49n 0.306p
A10 KEY2 ttl25_cin 50.0m 1.49n 0.306p
B10 KEY3 ttl25_cin 50.0m 1.49n 0.306p
P13 LED0 ttl25_cio_d8m 50.0m 1.49n 0.306p
P12 LED1 ttl25_cio_d8m 50.0m 1.49n 0.306p
N12 LED2 ttl25_cio_d8m 50.0m 1.49n 0.306p
N9 LED3 ttl25_cio_d8m 50.0m 1.49n 0.306p
U9 LINK_D0 ttl25_rdin 50.0m 1.49n 0.306p
U10 LINK_D1 ttl25_rdin 50.0m 1.49n 0.306p
V10 LINK_D2 ttl25_rdin 50.0m 1.49n 0.306p
F7 SRAM_ADSC_N ttl25_cio_d8m 50.0m 1.49n 0.306p
F10 SRAM_BE_N0 ttl25_cio_d8m 50.0m 1.49n 0.306p
F11 SRAM_BE_N1 ttl25_cio_d8m 50.0m 1.49n 0.306p
F12 SRAM_BE_N2 ttl25_cio_d8m 50.0m 1.49n 0.306p
F13 SRAM_BE_N3 ttl25_cio_d8m 50.0m 1.49n 0.306p
F9 SRAM_CE1_N ttl25_cio_d8m 50.0m 1.49n 0.306p
A2 SRAM_CLK ttl25_cio_d8m 50.0m 1.49n 0.306p
E9 SRAM_OE_N ttl25_cio_d8m 50.0m 1.49n 0.306p
G13 SRAM_WE_N ttl25_cio_d8m 50.0m 1.49n 0.306p
loc name ttl25_cio_d8m 50.0m 1.49n 0.306p
C11 GND  GND 50.0m 1.49n 0.306p
C13 GND  GND 50.0m 1.49n 0.306p
C15 GND  GND 50.0m 1.49n 0.306p
C4 GND  GND 50.0m 1.49n 0.306p
C6 GND  GND 50.0m 1.49n 0.306p
C8 GND  GND 50.0m 1.49n 0.306p
E16 GND  GND 50.0m 1.49n 0.306p
E3 GND  GND 50.0m 1.49n 0.306p
E5 GND  GND 50.0m 1.49n 0.306p
F15 GND  GND 50.0m 1.49n 0.306p
G16 GND  GND 50.0m 1.49n 0.306p
G3 GND  GND 50.0m 1.49n 0.306p
G9 GND  GND 50.0m 1.49n 0.306p
H10 GND  GND 50.0m 1.49n 0.306p
H11 GND  GND 50.0m 1.49n 0.306p
H8 GND  GND 50.0m 1.49n 0.306p
H9 GND  GND 50.0m 1.49n 0.306p
J10 GND  GND 50.0m 1.49n 0.306p
J11 GND  GND 50.0m 1.49n 0.306p
J16 GND  GND 50.0m 1.49n 0.306p
J17 GND  GND 50.0m 1.49n 0.306p
J3 GND  GND 50.0m 1.49n 0.306p
J8 GND  GND 50.0m 1.49n 0.306p
J9 GND  GND 50.0m 1.49n 0.306p
K10 GND  GND 50.0m 1.49n 0.306p
K11 GND  GND 50.0m 1.49n 0.306p
K16 GND  GND 50.0m 1.49n 0.306p
K3 GND  GND 50.0m 1.49n 0.306p
K8 GND  GND 50.0m 1.49n 0.306p
K9 GND  GND 50.0m 1.49n 0.306p
L10 GND  GND 50.0m 1.49n 0.306p
L11 GND  GND 50.0m 1.49n 0.306p
L8 GND  GND 50.0m 1.49n 0.306p
L9 GND  GND 50.0m 1.49n 0.306p
M10 GND  GND 50.0m 1.49n 0.306p
M16 GND  GND 50.0m 1.49n 0.306p
N3 GND  GND 50.0m 1.49n 0.306p
P14 GND  GND 50.0m 1.49n 0.306p
P16 GND  GND 50.0m 1.49n 0.306p
P3 GND  GND 50.0m 1.49n 0.306p
P5 GND  GND 50.0m 1.49n 0.306p
T10 GND  GND 50.0m 1.49n 0.306p
T12 GND  GND 50.0m 1.49n 0.306p
T15 GND  GND 50.0m 1.49n 0.306p
T5 GND  GND 50.0m 1.49n 0.306p
T7 GND  GND 50.0m 1.49n 0.306p
T9 GND  GND 50.0m 1.49n 0.306p
D11 VCC25  POWER 50.0m 1.49n 0.306p
D13 VCC25  POWER 50.0m 1.49n 0.306p
D15 VCC25  POWER 50.0m 1.49n 0.306p
D4 VCC25  POWER 50.0m 1.49n 0.306p
D6 VCC25  POWER 50.0m 1.49n 0.306p
D8 VCC25  POWER 50.0m 1.49n 0.306p
E15 VCC12  POWER 50.0m 1.49n 0.306p
E4 VCC25  POWER 50.0m 1.49n 0.306p
F14 VCC25  POWER 50.0m 1.49n 0.306p
F16 VCC25  POWER 50.0m 1.49n 0.306p
F4 VCC25  POWER 50.0m 1.49n 0.306p
F5 VCC12  POWER 50.0m 1.49n 0.306p
G10 VCC12  POWER 50.0m 1.49n 0.306p
G11 VCC12  POWER 50.0m 1.49n 0.306p
G12 VCC12  POWER 50.0m 1.49n 0.306p
G15 VCC25  POWER 50.0m 1.49n 0.306p
G4 VCC25  POWER 50.0m 1.49n 0.306p
G7 VCC12  POWER 50.0m 1.49n 0.306p
G8 VCC12  POWER 50.0m 1.49n 0.306p
H12 VCC12  POWER 50.0m 1.49n 0.306p
H7 VCC12  POWER 50.0m 1.49n 0.306p
J12 VCC12  POWER 50.0m 1.49n 0.306p
J14 VCC25  POWER 50.0m 1.49n 0.306p
J15 VCC25  POWER 50.0m 1.49n 0.306p
J18 VCC25  POWER 50.0m 1.49n 0.306p
J4 VCC25  POWER 50.0m 1.49n 0.306p
J7 VCC12  POWER 50.0m 1.49n 0.306p
K12 VCC12  POWER 50.0m 1.49n 0.306p
K13 VCC25  POWER 50.0m 1.49n 0.306p
K15 VCC25  POWER 50.0m 1.49n 0.306p
K4 VCC25  POWER 50.0m 1.49n 0.306p
K7 VCC12  POWER 50.0m 1.49n 0.306p
L12 VCC12  POWER 50.0m 1.49n 0.306p
L7 VCC12  POWER 50.0m 1.49n 0.306p
M11 VCC12  POWER 50.0m 1.49n 0.306p
M12 VCC12  POWER 50.0m 1.49n 0.306p
M15 VCC25  POWER 50.0m 1.49n 0.306p
M4 VCC25  POWER 50.0m 1.49n 0.306p
M7 VCC12  POWER 50.0m 1.49n 0.306p
M8 VCC12  POWER 50.0m 1.49n 0.306p
M9 VCC12  POWER 50.0m 1.49n 0.306p
N14 VCC25  POWER 50.0m 1.49n 0.306p
N4 VCC25  POWER 50.0m 1.49n 0.306p
N5 VCC25  POWER 50.0m 1.49n 0.306p
P15 VCC12  POWER 50.0m 1.49n 0.306p
P4 VCC12  POWER 50.0m 1.49n 0.306p
R10 VCC25  POWER 50.0m 1.49n 0.306p
R12 VCC25  POWER 50.0m 1.49n 0.306p
R14 VCC25  POWER 50.0m 1.49n 0.306p
R15 VCC25  POWER 50.0m 1.49n 0.306p
R6 VCC25  POWER 50.0m 1.49n 0.306p
R7 VCC25  POWER 50.0m 1.49n 0.306p
R9 VCC25  POWER 50.0m 1.49n 0.306p
T11 VCC125  POWER 50.0m 1.49n 0.306p
T6 VCC125  POWER 50.0m 1.49n 0.306p
[Diff_pin] inv_pin vdiff tdelay_typ tdelay_min tdelay_max
| The '+' pin is Diff_pin and the '-' pin is the inv_pin
U2   V2   NA   0 0 0
F17   F18   NA   0 0 0
N17   N18   NA   0 0 0
D14   C14   NA   0 0 0
U18   V18   NA   0 0 0
G17   G18   NA   0 0 0
K18   L18   NA   0 0 0
L16   M17   NA   0 0 0
L13   M14   NA   0 0 0
R17   R18   NA   0 0 0
M6   N6   NA   0 0 0
M13   N13   NA   0 0 0
C2   C1   NA   0 0 0
H2   H1   NA   0 0 0
K5   L5   NA   0 0 0
L4   L3   NA   0 0 0
P2   P1   NA   0 0 0
T3   R3   NA   0 0 0
E17   E18   NA   0 0 0
H17   H18   NA   0 0 0
L17   M18   NA   0 0 0
L14   L15   NA   0 0 0
P17   P18   NA   0 0 0
R5   R4   NA   0 0 0
T17   T18   NA   0 0 0
B2   B1   NA   0 0 0
G2   G1   NA   0 0 0
K2   K1   NA   0 0 0
L2   L1   NA   0 0 0
M2   M1   NA   0 0 0
R2   R1   NA   0 0 0
| Models and submodels in the file (8): lvds25_cin (Input), lvds25_co_e3r (Output), lvds25_rdin (Input), lvds25_ro_e3r (Output), ttl25_cin (Input), ttl25_cio_d8m (I/O), ttl25_rdin (Input), ttl25_rdio_d8m (I/O)
